* S3900 RX V2.8 HP3_LP7_2TRAP_12C - NETLIST SOLO PER STUDIO NON ESEGUITA
* R_L = omega(27MHz)*L/30, modello R constante (diverso dal modello ABCD a Q constante su f)
* Capacitori ideali; SPICE R-L-C standalone NO ERC NO PCB
V1 SRC 0 AC 1
RS SRC N0 50
C1 N0 N1 2.65258238e-10
L2 N1 P2 3.31572798e-07
RL2 P2 0 1.875
C3 N1 N3 2.65258238e-10
L4 N3 P4 1.8e-07
RL4 P4 N4 1.017876
CT4 N3 N4 5.6e-11
C5 N4 0 1.2e-10
L6 N4 P6 4.7e-07
RL6 P6 N6 2.6577874
C7 N6 0 1.4e-10
L8 N6 P8 4.7e-07
RL8 P8 N8 2.6577874
C9 N8 0 1.2e-10
L10 N8 P10 1.8e-07
RL10 P10 N10 1.017876
CT10 N8 N10 6.2e-11
RLOAD N10 0 50
.ac dec 150 1Meg 70Meg
.print ac vm(N10)
.end

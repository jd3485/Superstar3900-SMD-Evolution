* S3900 RX V2.8 LP7_2TRAP_9C - NETLIST SOLO PER STUDIO NON ESEGUITA
* R_L = omega(27MHz)*L/30, modello R constante (diverso dal modello ABCD a Q constante su f)
* Capacitori ideali; SPICE R-L-C standalone NO ERC NO PCB
V1 SRC 0 AC 1
RS SRC N0 50
L1 N0 P1 1.8e-07
RL1 P1 N1 1.017876
CT1 N0 N1 5.6e-11
C2 N1 0 1.2e-10
L3 N1 P3 4.7e-07
RL3 P3 N3 2.6577874
C4 N3 0 1.4e-10
L5 N3 P5 4.7e-07
RL5 P5 N5 2.6577874
C6 N5 0 1.2e-10
L7 N5 P7 1.8e-07
RL7 P7 N7 1.017876
CT7 N5 N7 6.2e-11
RLOAD N7 0 50
.ac dec 150 1Meg 70Meg
.print ac vm(N7)
.end

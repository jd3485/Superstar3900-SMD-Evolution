* V7.0 actual lumped-element passive LPF only. 50ohm 10.24MHz LO2. NOT Si5351 or GALI nonlinear models.
V1 in 0 AC 1
RSOURCE in n0 50
L1 n0 n1 330n
RLS1 n1 n1r 0.266
C1 n1r 0 360p
L2 n1r n2 1.1u
RLS2 n2 n2r 0.885
C2 n2r 0 360p
L3 n2r out 330n
RLS3 out load 0.266
RLOAD load 0 50
.AC DEC 100 1MEG 100MEG
.PRINT AC VM(load)
.END
